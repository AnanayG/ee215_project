ADE simulation setup
Run mode: Single Run, Sweeps and Corners
Tests:
  ee215_project:charac:1: ee215_project/charac/schematic, simulator spectre
Global variables:
  Vds = 1000m
  Vgs = 800m 900m 1000m 1050m 1100m 1150m 1200m
  corner_factor = 1
  mismatch_factor = 1
  process_mc_factor = 1
